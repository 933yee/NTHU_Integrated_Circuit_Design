* File: INV_pex.cir
* Created: Sun Nov 24 21:52:00 2024
* Program "Calibre xRC"
* Version "v2020.2_14.12"
*
.include "INV_pex.cir.pex"
.subckt XOR  C B A S GND VDD
*
* VDD	VDD
* GND	GND
* S	S
* A	A
* B	B
* C	C
M0 N_GND_M0_d N_C_M0_g N_1_M0_s N_GND_M0_b N_18 L=1.8e-07 W=6e-07 AD=6.9e-13
+ AS=1.068e-12 PD=2.9e-06 PS=4.16e-06
M1 N_GND_M1_d N_A_M1_g N_3_M1_s N_GND_M0_b N_18 L=1.8e-07 W=6e-07 AD=8.1e-13
+ AS=8.28e-13 PD=3.3e-06 PS=3.36e-06
M2 N_5_M2_d N_A_M2_g N_GND_M2_s N_GND_M0_b N_18 L=1.8e-07 W=6e-07 AD=4.86e-13
+ AS=9.6e-13 PD=1.62e-06 PS=3.8e-06
M3 N_8_M3_d N_B_M3_g N_5_M3_s N_GND_M0_b N_18 L=1.8e-07 W=6e-07 AD=4.56e-13
+ AS=4.86e-13 PD=1.52e-06 PS=1.62e-06
M4 N_S_M4_d N_1_M4_g N_8_M4_s N_GND_M0_b N_18 L=1.8e-07 W=6e-07 AD=6.72e-13
+ AS=4.56e-13 PD=2.84e-06 PS=1.52e-06
M5 N_10_M5_d N_9_M5_g N_5_M5_s N_GND_M0_b N_18 L=1.8e-07 W=6e-07 AD=7.8e-13
+ AS=6.72e-13 PD=3.2e-06 PS=2.84e-06
M6 N_13_M6_d N_9_M6_g N_8_M6_s N_GND_M0_b N_18 L=1.8e-07 W=6e-07 AD=7.2e-13
+ AS=7.32e-13 PD=3e-06 PS=3.04e-06
M7 N_10_M7_d N_C_M7_g N_S_M7_s N_GND_M0_b N_18 L=1.8e-07 W=6e-07 AD=4.86e-13
+ AS=1.02e-12 PD=1.62e-06 PS=4e-06
M8 N_13_M8_d N_B_M8_g N_10_M8_s N_GND_M0_b N_18 L=1.8e-07 W=6e-07 AD=4.56e-13
+ AS=4.86e-13 PD=1.52e-06 PS=1.62e-06
M9 N_GND_M9_d N_3_M9_g N_13_M9_s N_GND_M0_b N_18 L=1.8e-07 W=6e-07 AD=7.92e-13
+ AS=4.56e-13 PD=3.24e-06 PS=1.52e-06
M10 N_9_M10_d N_B_M10_g N_GND_M10_s N_GND_M0_b N_18 L=1.8e-07 W=6e-07 AD=6.9e-13
+ AS=8.88e-13 PD=2.9e-06 PS=3.56e-06
M11 N_VDD_M11_d N_C_M11_g N_1_M11_s N_VDD_M11_b P_18 L=1.8e-07 W=1.2e-06
+ AD=1.548e-12 AS=1.764e-12 PD=3.78e-06 PS=4.14e-06
M12 N_VDD_M12_d N_A_M12_g N_3_M12_s N_VDD_M11_b P_18 L=1.8e-07 W=1.2e-06
+ AD=1.668e-12 AS=1.644e-12 PD=3.98e-06 PS=3.94e-06
M13 N_6_M13_d N_A_M13_g N_VDD_M13_s N_VDD_M11_b P_18 L=1.8e-07 W=1.2e-06
+ AD=9.72e-13 AS=2.16e-12 PD=1.62e-06 PS=4.8e-06
M14 N_7_M14_d N_B_M14_g N_6_M14_s N_VDD_M11_b P_18 L=1.8e-07 W=1.2e-06
+ AD=9.12e-13 AS=9.72e-13 PD=1.52e-06 PS=1.62e-06
M15 N_S_M15_d N_1_M15_g N_7_M15_s N_VDD_M11_b P_18 L=1.8e-07 W=1.2e-06
+ AD=1.344e-12 AS=9.12e-13 PD=3.44e-06 PS=1.52e-06
M16 N_11_M16_d N_9_M16_g N_6_M16_s N_VDD_M11_b P_18 L=1.8e-07 W=1.2e-06
+ AD=1.68e-12 AS=1.464e-12 PD=4e-06 PS=3.64e-06
M17 N_12_M17_d N_9_M17_g N_7_M17_s N_VDD_M11_b P_18 L=1.8e-07 W=1.2e-06
+ AD=1.68e-12 AS=1.224e-12 PD=4e-06 PS=3.24e-06
M18 N_11_M18_d N_C_M18_g N_S_M18_s N_VDD_M11_b P_18 L=1.8e-07 W=1.2e-06
+ AD=9.72e-13 AS=2.16e-12 PD=1.62e-06 PS=4.8e-06
M19 N_12_M19_d N_B_M19_g N_11_M19_s N_VDD_M11_b P_18 L=1.8e-07 W=1.2e-06
+ AD=9.12e-13 AS=9.72e-13 PD=1.52e-06 PS=1.62e-06
M20 N_VDD_M20_d N_3_M20_g N_12_M20_s N_VDD_M11_b P_18 L=1.8e-07 W=1.2e-06
+ AD=1.344e-12 AS=9.12e-13 PD=3.44e-06 PS=1.52e-06
M21 N_9_M21_d N_B_M21_g N_VDD_M21_s N_VDD_M11_b P_18 L=1.8e-07 W=1.2e-06
+ AD=1.308e-12 AS=2.244e-12 PD=3.38e-06 PS=4.94e-06
*
.include "INV_pex.cir.XOR.pxi"
*
.ends
*
*
